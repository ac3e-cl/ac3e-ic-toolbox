`include "disciplines.vams"
module smoke_resistor(p, n);
  inout p, n;
  electrical p, n;
  parameter real resistance = 1000 from (0:inf);
  analog I(p, n) <+ V(p, n) / resistance;
endmodule
